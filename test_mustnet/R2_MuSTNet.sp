// Path statistics: a: 3; b: 3;
.subckt R2_MuSTNet GND VCC Y a b
.model nmos NMOS level=1 VTO=0.4 KP=120u
.model pmos PMOS level=1 VTO=-0.4 KP=40u

M0 Y b pN1 VCC PMOS W=1u L=0.05u
+ ad=0p pd=0u as=0p ps=0u
M1 pN1 a VCC VCC PMOS W=1u L=0.05u
+ ad=0p pd=0u as=0p ps=0u
M2 Y b GND GND NMOS W=0.25u L=0.05u
+ ad=0p pd=0u as=0p ps=0u
M3 Y a GND GND NMOS W=0.25u L=0.05u
+ ad=0p pd=0u as=0p ps=0u
.end
