// Path statistics: !a: 5; !b: 5; !c: 10; a: 5; b: 5; c: 10; d: 5;
.subckt 361_MuSTNet GND VCC Y a b c d
.model nmos NMOS level=1 VTO=0.4 KP=120u
.model pmos PMOS level=1 VTO=-0.4 KP=40u

M0 !a a VCC VCC PMOS W=0.5u L=0.05u
+ ad=0p pd=0u as=0p ps=0u
M1 !b b VCC VCC PMOS W=0.5u L=0.05u
+ ad=0p pd=0u as=0p ps=0u
M2 !c c VCC VCC PMOS W=0.5u L=0.05u
+ ad=0p pd=0u as=0p ps=0u
M3 nN4 a nN1 GND NMOS W=1.25u L=0.05u
+ ad=0p pd=0u as=0p ps=0u
M4 nN2 b nN1 GND NMOS W=1.25u L=0.05u
+ ad=0p pd=0u as=0p ps=0u
M5 !c c GND GND NMOS W=0.25u L=0.05u
+ ad=0p pd=0u as=0p ps=0u
M6 nN2 d GND GND NMOS W=1.25u L=0.05u
+ ad=0p pd=0u as=0p ps=0u
M7 nN7 !a nN2 GND NMOS W=1.25u L=0.05u
+ ad=0p pd=0u as=0p ps=0u
M8 nN7 !b nN4 GND NMOS W=1.25u L=0.05u
+ ad=0p pd=0u as=0p ps=0u
M9 Y c nN2 GND NMOS W=1.25u L=0.05u
+ ad=0p pd=0u as=0p ps=0u
M10 nN7 !c GND GND NMOS W=1.25u L=0.05u
+ ad=0p pd=0u as=0p ps=0u
M11 nN4 c GND GND NMOS W=1.25u L=0.05u
+ ad=0p pd=0u as=0p ps=0u
M12 !a a GND GND NMOS W=0.25u L=0.05u
+ ad=0p pd=0u as=0p ps=0u
M13 !b b GND GND NMOS W=0.25u L=0.05u
+ ad=0p pd=0u as=0p ps=0u
M14 Y !c nN1 GND NMOS W=1.25u L=0.05u
+ ad=0p pd=0u as=0p ps=0u
.end
