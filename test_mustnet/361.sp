// Path statistics: !a: 4; !b: 4; !c: 8; a: 4; b: 4; c: 8; d: 3;
.subckt 361 GND VCC Y a b c d
.model nmos NMOS level=1 VTO=0.4 KP=120u
.model pmos PMOS level=1 VTO=-0.4 KP=40u

M0 !a a VCC VCC PMOS W=0.5u L=0.05u
+ ad=0p pd=0u as=0p ps=0u
M1 !b b VCC VCC PMOS W=0.5u L=0.05u
+ ad=0p pd=0u as=0p ps=0u
M2 !c c VCC VCC PMOS W=0.5u L=0.05u
+ ad=0p pd=0u as=0p ps=0u
M3 nN2 a nN1 GND NMOS W=1u L=0.05u
+ ad=0p pd=0u as=0p ps=0u
M4 nN3 b nN2 GND NMOS W=1u L=0.05u
+ ad=0p pd=0u as=0p ps=0u
M5 !c c GND GND NMOS W=0.25u L=0.05u
+ ad=0p pd=0u as=0p ps=0u
M6 Y c nN3 GND NMOS W=1u L=0.05u
+ ad=0p pd=0u as=0p ps=0u
M7 nN4 !a nN3 GND NMOS W=1u L=0.05u
+ ad=0p pd=0u as=0p ps=0u
M8 nN4 !b nN1 GND NMOS W=1u L=0.05u
+ ad=0p pd=0u as=0p ps=0u
M9 Y d nN1 GND NMOS W=0.75u L=0.05u
+ ad=0p pd=0u as=0p ps=0u
M10 nN1 c GND GND NMOS W=1u L=0.05u
+ ad=0p pd=0u as=0p ps=0u
M11 nN2 !c GND GND NMOS W=1u L=0.05u
+ ad=0p pd=0u as=0p ps=0u
M12 !a a GND GND NMOS W=0.25u L=0.05u
+ ad=0p pd=0u as=0p ps=0u
M13 !b b GND GND NMOS W=0.25u L=0.05u
+ ad=0p pd=0u as=0p ps=0u
M14 Y !c nN4 GND NMOS W=1u L=0.05u
+ ad=0p pd=0u as=0p ps=0u
.end
