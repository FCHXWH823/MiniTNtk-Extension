// Path statistics:
.subckt 361 GND VCC Y
.model nmos NMOS level=1 VTO=0.4 KP=120u
.model pmos PMOS level=1 VTO=-0.4 KP=40u

.end
