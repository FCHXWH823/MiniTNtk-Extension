// Path statistics: a: 7; b: 6; c: 7; d: 6; e: 7; f: 7;
.subckt NSP_10 GND VCC Y a b c d e f
.model nmos NMOS level=1 VTO=0.4 KP=120u
.model pmos PMOS level=1 VTO=-0.4 KP=40u

M0 Y e pN2 VCC PMOS W=1.5u L=0.05u
+ ad=0p pd=0u as=0p ps=0u
M1 pN2 b VCC VCC PMOS W=1.5u L=0.05u
+ ad=0p pd=0u as=0p ps=0u
M2 pN2 c pN1 VCC PMOS W=1.5u L=0.05u
+ ad=0p pd=0u as=0p ps=0u
M3 pN1 a VCC VCC PMOS W=1.5u L=0.05u
+ ad=0p pd=0u as=0p ps=0u
M4 Y d pN1 VCC PMOS W=1.5u L=0.05u
+ ad=0p pd=0u as=0p ps=0u
M5 pN1 f VCC VCC PMOS W=1.5u L=0.05u
+ ad=0p pd=0u as=0p ps=0u
M6 nN1 a nN2 GND NMOS W=1u L=0.05u
+ ad=0p pd=0u as=0p ps=0u
M7 nN2 f GND GND NMOS W=1u L=0.05u
+ ad=0p pd=0u as=0p ps=0u
M8 nN3 c nN1 GND NMOS W=1u L=0.05u
+ ad=0p pd=0u as=0p ps=0u
M9 nN3 d GND GND NMOS W=0.75u L=0.05u
+ ad=0p pd=0u as=0p ps=0u
M10 Y b nN1 GND NMOS W=0.75u L=0.05u
+ ad=0p pd=0u as=0p ps=0u
M11 Y e nN3 GND NMOS W=1u L=0.05u
+ ad=0p pd=0u as=0p ps=0u
.end
