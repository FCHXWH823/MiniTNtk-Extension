// Path statistics: a: 14; b: 7; c: 7; d: 7; e: 6; f: 6;
.subckt NSP_15_DepthLimited GND VCC Y a b c d e f
.model nmos NMOS level=1 VTO=0.4 KP=120u
.model pmos PMOS level=1 VTO=-0.4 KP=40u

M0 Y e pN2 VCC PMOS W=1u L=0.05u
+ ad=0p pd=0u as=0p ps=0u
M1 pN1 b VCC VCC PMOS W=1.5u L=0.05u
+ ad=0p pd=0u as=0p ps=0u
M2 pN1 c pN3 VCC PMOS W=1.5u L=0.05u
+ ad=0p pd=0u as=0p ps=0u
M3 Y a pN1 VCC PMOS W=1.5u L=0.05u
+ ad=0p pd=0u as=0p ps=0u
M4 Y d pN3 VCC PMOS W=1.5u L=0.05u
+ ad=0p pd=0u as=0p ps=0u
M5 pN2 f VCC VCC PMOS W=1u L=0.05u
+ ad=0p pd=0u as=0p ps=0u
M6 pN3 a VCC VCC PMOS W=1.5u L=0.05u
+ ad=0p pd=0u as=0p ps=0u
M7 nN1 a nN3 GND NMOS W=1u L=0.05u
+ ad=0p pd=0u as=0p ps=0u
M8 nN2 b nN3 GND NMOS W=1u L=0.05u
+ ad=0p pd=0u as=0p ps=0u
M9 Y a nN2 GND NMOS W=1u L=0.05u
+ ad=0p pd=0u as=0p ps=0u
M10 nN1 d nN2 GND NMOS W=1u L=0.05u
+ ad=0p pd=0u as=0p ps=0u
M11 nN3 e GND GND NMOS W=1u L=0.05u
+ ad=0p pd=0u as=0p ps=0u
M12 nN3 f GND GND NMOS W=1u L=0.05u
+ ad=0p pd=0u as=0p ps=0u
M13 Y c nN1 GND NMOS W=1u L=0.05u
+ ad=0p pd=0u as=0p ps=0u
.end
