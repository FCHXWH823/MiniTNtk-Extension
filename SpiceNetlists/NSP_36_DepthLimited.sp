// Path statistics: a: 11; b: 10; c: 9; d: 10; e: 7; f: 10;
.subckt NSP_36_DepthLimited GND VCC Y a b c d e f
.model nmos NMOS level=1 VTO=0.4 KP=120u
.model pmos PMOS level=1 VTO=-0.4 KP=40u

M0 Y d pN4 VCC PMOS W=1.5u L=0.05u
+ ad=0p pd=0u as=0p ps=0u
M1 pN3 b VCC VCC PMOS W=1.5u L=0.05u
+ ad=0p pd=0u as=0p ps=0u
M2 pN1 c VCC VCC PMOS W=1u L=0.05u
+ ad=0p pd=0u as=0p ps=0u
M3 pN3 d VCC VCC PMOS W=1.5u L=0.05u
+ ad=0p pd=0u as=0p ps=0u
M4 pN1 e pN3 VCC PMOS W=1.5u L=0.05u
+ ad=0p pd=0u as=0p ps=0u
M5 Y a pN1 VCC PMOS W=1.5u L=0.05u
+ ad=0p pd=0u as=0p ps=0u
M6 pN4 c pN2 VCC PMOS W=1.5u L=0.05u
+ ad=0p pd=0u as=0p ps=0u
M7 Y f pN4 VCC PMOS W=1.5u L=0.05u
+ ad=0p pd=0u as=0p ps=0u
M8 pN3 f VCC VCC PMOS W=1.5u L=0.05u
+ ad=0p pd=0u as=0p ps=0u
M9 pN2 b VCC VCC PMOS W=1.5u L=0.05u
+ ad=0p pd=0u as=0p ps=0u
M10 nN3 a GND GND NMOS W=1u L=0.05u
+ ad=0p pd=0u as=0p ps=0u
M11 nN1 b GND GND NMOS W=1u L=0.05u
+ ad=0p pd=0u as=0p ps=0u
M12 Y a nN1 GND NMOS W=1u L=0.05u
+ ad=0p pd=0u as=0p ps=0u
M13 nN2 d nN3 GND NMOS W=1u L=0.05u
+ ad=0p pd=0u as=0p ps=0u
M14 nN3 e GND GND NMOS W=1u L=0.05u
+ ad=0p pd=0u as=0p ps=0u
M15 nN2 f nN1 GND NMOS W=1u L=0.05u
+ ad=0p pd=0u as=0p ps=0u
M16 Y c nN3 GND NMOS W=1u L=0.05u
+ ad=0p pd=0u as=0p ps=0u
.end
