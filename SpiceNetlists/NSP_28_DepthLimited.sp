// Path statistics: a: 16; b: 8; c: 8; d: 8; e: 8; f: 8;
.subckt NSP_28_DepthLimited GND VCC Y a b c d e f
.model nmos NMOS level=1 VTO=0.4 KP=120u
.model pmos PMOS level=1 VTO=-0.4 KP=40u

M0 Y a pN2 VCC PMOS W=2.5u L=0.05u
+ ad=0p pd=0u as=0p ps=0u
M1 pN2 b VCC VCC PMOS W=2.5u L=0.05u
+ ad=0p pd=0u as=0p ps=0u
M2 pN4 c pN3 VCC PMOS W=2.5u L=0.05u
+ ad=0p pd=0u as=0p ps=0u
M3 pN1 a VCC VCC PMOS W=2.5u L=0.05u
+ ad=0p pd=0u as=0p ps=0u
M4 pN1 e pN3 VCC PMOS W=2.5u L=0.05u
+ ad=0p pd=0u as=0p ps=0u
M5 pN4 f pN2 VCC PMOS W=2.5u L=0.05u
+ ad=0p pd=0u as=0p ps=0u
M6 Y d pN1 VCC PMOS W=2.5u L=0.05u
+ ad=0p pd=0u as=0p ps=0u
M7 nN2 a GND GND NMOS W=0.75u L=0.05u
+ ad=0p pd=0u as=0p ps=0u
M8 nN2 b nN1 GND NMOS W=0.75u L=0.05u
+ ad=0p pd=0u as=0p ps=0u
M9 Y a nN1 GND NMOS W=0.75u L=0.05u
+ ad=0p pd=0u as=0p ps=0u
M10 nN1 d GND GND NMOS W=0.75u L=0.05u
+ ad=0p pd=0u as=0p ps=0u
M11 Y c nN2 GND NMOS W=0.75u L=0.05u
+ ad=0p pd=0u as=0p ps=0u
M12 Y e nN2 GND NMOS W=0.75u L=0.05u
+ ad=0p pd=0u as=0p ps=0u
M13 Y f nN2 GND NMOS W=0.75u L=0.05u
+ ad=0p pd=0u as=0p ps=0u
.end
