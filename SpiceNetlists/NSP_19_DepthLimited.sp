// Path statistics: a: 10; b: 11; c: 11; d: 10; e: 7; f: 5;
.subckt NSP_19_DepthLimited GND VCC Y a b c d e f
.model nmos NMOS level=1 VTO=0.4 KP=120u
.model pmos PMOS level=1 VTO=-0.4 KP=40u

M0 Y f VCC VCC PMOS W=0.5u L=0.05u
+ ad=0p pd=0u as=0p ps=0u
M1 pN1 b pN2 VCC PMOS W=1.5u L=0.05u
+ ad=0p pd=0u as=0p ps=0u
M2 pN2 c VCC VCC PMOS W=1.5u L=0.05u
+ ad=0p pd=0u as=0p ps=0u
M3 Y a pN2 VCC PMOS W=1.5u L=0.05u
+ ad=0p pd=0u as=0p ps=0u
M4 pN1 e VCC VCC PMOS W=1.5u L=0.05u
+ ad=0p pd=0u as=0p ps=0u
M5 Y d pN1 VCC PMOS W=1.5u L=0.05u
+ ad=0p pd=0u as=0p ps=0u
M6 pN1 a VCC VCC PMOS W=1.5u L=0.05u
+ ad=0p pd=0u as=0p ps=0u
M7 nN1 a GND GND NMOS W=1u L=0.05u
+ ad=0p pd=0u as=0p ps=0u
M8 nN3 b nN2 GND NMOS W=1u L=0.05u
+ ad=0p pd=0u as=0p ps=0u
M9 nN4 c nN1 GND NMOS W=1u L=0.05u
+ ad=0p pd=0u as=0p ps=0u
M10 nN2 d nN5 GND NMOS W=1u L=0.05u
+ ad=0p pd=0u as=0p ps=0u
M11 nN3 e nN4 GND NMOS W=1u L=0.05u
+ ad=0p pd=0u as=0p ps=0u
M12 nN3 d nN1 GND NMOS W=0.75u L=0.05u
+ ad=0p pd=0u as=0p ps=0u
M13 nN5 c GND GND NMOS W=1u L=0.05u
+ ad=0p pd=0u as=0p ps=0u
M14 nN4 b nN1 GND NMOS W=1u L=0.05u
+ ad=0p pd=0u as=0p ps=0u
M15 Y f nN3 GND NMOS W=1u L=0.05u
+ ad=0p pd=0u as=0p ps=0u
.end
