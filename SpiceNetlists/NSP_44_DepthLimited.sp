// Path statistics: a: 9; b: 11; c: 9; d: 12; e: 6; f: 9;
.subckt NSP_44_DepthLimited GND VCC Y a b c d e f
.model nmos NMOS level=1 VTO=0.4 KP=120u
.model pmos PMOS level=1 VTO=-0.4 KP=40u

M0 Y f pN3 VCC PMOS W=1.5u L=0.05u
+ ad=0p pd=0u as=0p ps=0u
M1 pN3 b VCC VCC PMOS W=1.5u L=0.05u
+ ad=0p pd=0u as=0p ps=0u
M2 Y a pN1 VCC PMOS W=1.5u L=0.05u
+ ad=0p pd=0u as=0p ps=0u
M3 pN3 d pN4 VCC PMOS W=1.5u L=0.05u
+ ad=0p pd=0u as=0p ps=0u
M4 pN1 e pN2 VCC PMOS W=1.5u L=0.05u
+ ad=0p pd=0u as=0p ps=0u
M5 Y c pN4 VCC PMOS W=1.5u L=0.05u
+ ad=0p pd=0u as=0p ps=0u
M6 pN2 b VCC VCC PMOS W=1.5u L=0.05u
+ ad=0p pd=0u as=0p ps=0u
M7 pN4 a VCC VCC PMOS W=1.5u L=0.05u
+ ad=0p pd=0u as=0p ps=0u
M8 pN2 d VCC VCC PMOS W=1.5u L=0.05u
+ ad=0p pd=0u as=0p ps=0u
M9 nN1 c GND GND NMOS W=0.75u L=0.05u
+ ad=0p pd=0u as=0p ps=0u
M10 nN2 b GND GND NMOS W=0.5u L=0.05u
+ ad=0p pd=0u as=0p ps=0u
M11 nN2 c nN3 GND NMOS W=0.75u L=0.05u
+ ad=0p pd=0u as=0p ps=0u
M12 Y a nN2 GND NMOS W=0.75u L=0.05u
+ ad=0p pd=0u as=0p ps=0u
M13 Y d nN4 GND NMOS W=0.75u L=0.05u
+ ad=0p pd=0u as=0p ps=0u
M14 nN5 f nN1 GND NMOS W=0.75u L=0.05u
+ ad=0p pd=0u as=0p ps=0u
M15 nN4 b nN1 GND NMOS W=0.75u L=0.05u
+ ad=0p pd=0u as=0p ps=0u
M16 nN3 f GND GND NMOS W=0.75u L=0.05u
+ ad=0p pd=0u as=0p ps=0u
M17 nN2 d nN3 GND NMOS W=0.75u L=0.05u
+ ad=0p pd=0u as=0p ps=0u
M18 Y e nN5 GND NMOS W=0.75u L=0.05u
+ ad=0p pd=0u as=0p ps=0u
.end
