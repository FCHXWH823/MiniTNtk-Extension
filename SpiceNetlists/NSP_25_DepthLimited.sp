// Path statistics: a: 9; b: 9; c: 9; d: 11; e: 6; f: 6;
.subckt NSP_25_DepthLimited GND VCC Y a b c d e f
.model nmos NMOS level=1 VTO=0.4 KP=120u
.model pmos PMOS level=1 VTO=-0.4 KP=40u

M0 Y a pN2 VCC PMOS W=1.5u L=0.05u
+ ad=0p pd=0u as=0p ps=0u
M1 pN2 b VCC VCC PMOS W=1.5u L=0.05u
+ ad=0p pd=0u as=0p ps=0u
M2 pN1 a VCC VCC PMOS W=1.5u L=0.05u
+ ad=0p pd=0u as=0p ps=0u
M3 pN1 d pN2 VCC PMOS W=1.5u L=0.05u
+ ad=0p pd=0u as=0p ps=0u
M4 pN4 e pN3 VCC PMOS W=1.5u L=0.05u
+ ad=0p pd=0u as=0p ps=0u
M5 Y c pN1 VCC PMOS W=1.5u L=0.05u
+ ad=0p pd=0u as=0p ps=0u
M6 Y f pN4 VCC PMOS W=1.5u L=0.05u
+ ad=0p pd=0u as=0p ps=0u
M7 pN3 d VCC VCC PMOS W=1.5u L=0.05u
+ ad=0p pd=0u as=0p ps=0u
M8 nN1 a GND GND NMOS W=0.75u L=0.05u
+ ad=0p pd=0u as=0p ps=0u
M9 nN3 b nN2 GND NMOS W=0.75u L=0.05u
+ ad=0p pd=0u as=0p ps=0u
M10 nN4 b nN1 GND NMOS W=0.75u L=0.05u
+ ad=0p pd=0u as=0p ps=0u
M11 nN2 d GND GND NMOS W=0.75u L=0.05u
+ ad=0p pd=0u as=0p ps=0u
M12 Y c nN3 GND NMOS W=0.75u L=0.05u
+ ad=0p pd=0u as=0p ps=0u
M13 Y e nN4 GND NMOS W=0.75u L=0.05u
+ ad=0p pd=0u as=0p ps=0u
M14 Y f nN4 GND NMOS W=0.75u L=0.05u
+ ad=0p pd=0u as=0p ps=0u
M15 nN4 c nN1 GND NMOS W=0.75u L=0.05u
+ ad=0p pd=0u as=0p ps=0u
M16 Y d nN1 GND NMOS W=0.5u L=0.05u
+ ad=0p pd=0u as=0p ps=0u
.end
