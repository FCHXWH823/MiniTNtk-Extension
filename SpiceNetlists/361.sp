// Path statistics: !a: 8; !b: 12; !c: 12; a: 8; b: 11; c: 12; d: 7;
.subckt 361 GND VCC Y a b c d
.model nmos NMOS level=1 VTO=0.4 KP=120u
.model pmos PMOS level=1 VTO=-0.4 KP=40u

M0 Y d pN4 VCC PMOS W=2u L=0.05u
+ ad=0p pd=0u as=0p ps=0u
M1 pN1 a VCC VCC PMOS W=2u L=0.05u
+ ad=0p pd=0u as=0p ps=0u
M2 pN3 c pN1 VCC PMOS W=2u L=0.05u
+ ad=0p pd=0u as=0p ps=0u
M3 Y b pN3 VCC PMOS W=1.5u L=0.05u
+ ad=0p pd=0u as=0p ps=0u
M4 pN4 !a pN1 VCC PMOS W=2u L=0.05u
+ ad=0p pd=0u as=0p ps=0u
M5 pN4 !b pN2 VCC PMOS W=2u L=0.05u
+ ad=0p pd=0u as=0p ps=0u
M6 pN2 !c pN1 VCC PMOS W=2u L=0.05u
+ ad=0p pd=0u as=0p ps=0u
M7 pN2 b VCC VCC PMOS W=2u L=0.05u
+ ad=0p pd=0u as=0p ps=0u
M8 pN3 !b VCC VCC PMOS W=2u L=0.05u
+ ad=0p pd=0u as=0p ps=0u
M9 !a a VCC VCC PMOS W=0.5u L=0.05u
+ ad=0p pd=0u as=0p ps=0u
M10 !b b VCC VCC PMOS W=0.5u L=0.05u
+ ad=0p pd=0u as=0p ps=0u
M11 !c c VCC VCC PMOS W=0.5u L=0.05u
+ ad=0p pd=0u as=0p ps=0u
M12 nN2 a nN1 GND NMOS W=1u L=0.05u
+ ad=0p pd=0u as=0p ps=0u
M13 nN3 b nN2 GND NMOS W=1u L=0.05u
+ ad=0p pd=0u as=0p ps=0u
M14 !c c GND GND NMOS W=0.25u L=0.05u
+ ad=0p pd=0u as=0p ps=0u
M15 Y c nN3 GND NMOS W=1u L=0.05u
+ ad=0p pd=0u as=0p ps=0u
M16 nN4 !a nN3 GND NMOS W=1u L=0.05u
+ ad=0p pd=0u as=0p ps=0u
M17 nN4 !b nN1 GND NMOS W=1u L=0.05u
+ ad=0p pd=0u as=0p ps=0u
M18 Y d nN1 GND NMOS W=0.75u L=0.05u
+ ad=0p pd=0u as=0p ps=0u
M19 nN1 c GND GND NMOS W=1u L=0.05u
+ ad=0p pd=0u as=0p ps=0u
M20 nN2 !c GND GND NMOS W=1u L=0.05u
+ ad=0p pd=0u as=0p ps=0u
M21 !a a GND GND NMOS W=0.25u L=0.05u
+ ad=0p pd=0u as=0p ps=0u
M22 !b b GND GND NMOS W=0.25u L=0.05u
+ ad=0p pd=0u as=0p ps=0u
M23 Y !c nN4 GND NMOS W=1u L=0.05u
+ ad=0p pd=0u as=0p ps=0u
.end
