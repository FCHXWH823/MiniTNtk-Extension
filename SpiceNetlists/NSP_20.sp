// Path statistics: a: 16; b: 7; c: 8; d: 7; e: 8; f: 5;
.subckt NSP_20 GND VCC Y a b c d e f
.model nmos NMOS level=1 VTO=0.4 KP=120u
.model pmos PMOS level=1 VTO=-0.4 KP=40u

M0 Y f pN3 VCC PMOS W=2u L=0.05u
+ ad=0p pd=0u as=0p ps=0u
M1 pN2 b pN1 VCC PMOS W=2u L=0.05u
+ ad=0p pd=0u as=0p ps=0u
M2 pN2 c VCC VCC PMOS W=2u L=0.05u
+ ad=0p pd=0u as=0p ps=0u
M3 pN3 d pN1 VCC PMOS W=2u L=0.05u
+ ad=0p pd=0u as=0p ps=0u
M4 pN1 e VCC VCC PMOS W=2u L=0.05u
+ ad=0p pd=0u as=0p ps=0u
M5 pN1 a VCC VCC PMOS W=2u L=0.05u
+ ad=0p pd=0u as=0p ps=0u
M6 pN3 a pN2 VCC PMOS W=2u L=0.05u
+ ad=0p pd=0u as=0p ps=0u
M7 nN2 a nN1 GND NMOS W=1u L=0.05u
+ ad=0p pd=0u as=0p ps=0u
M8 Y a nN3 GND NMOS W=1u L=0.05u
+ ad=0p pd=0u as=0p ps=0u
M9 nN3 c nN2 GND NMOS W=1u L=0.05u
+ ad=0p pd=0u as=0p ps=0u
M10 nN3 d GND GND NMOS W=0.75u L=0.05u
+ ad=0p pd=0u as=0p ps=0u
M11 nN1 e GND GND NMOS W=1u L=0.05u
+ ad=0p pd=0u as=0p ps=0u
M12 Y b nN2 GND NMOS W=0.75u L=0.05u
+ ad=0p pd=0u as=0p ps=0u
M13 Y f GND GND NMOS W=0.25u L=0.05u
+ ad=0p pd=0u as=0p ps=0u
.end
