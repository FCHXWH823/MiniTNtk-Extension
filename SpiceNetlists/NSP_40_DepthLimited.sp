// Path statistics: a: 9; b: 10; c: 9; d: 10; e: 6; f: 10;
.subckt NSP_40_DepthLimited GND VCC Y a b c d e f
.model nmos NMOS level=1 VTO=0.4 KP=120u
.model pmos PMOS level=1 VTO=-0.4 KP=40u

M0 Y d pN3 VCC PMOS W=1.5u L=0.05u
+ ad=0p pd=0u as=0p ps=0u
M1 pN2 b VCC VCC PMOS W=1.5u L=0.05u
+ ad=0p pd=0u as=0p ps=0u
M2 pN3 c pN2 VCC PMOS W=1.5u L=0.05u
+ ad=0p pd=0u as=0p ps=0u
M3 pN1 a VCC VCC PMOS W=1.5u L=0.05u
+ ad=0p pd=0u as=0p ps=0u
M4 pN4 e pN1 VCC PMOS W=1.5u L=0.05u
+ ad=0p pd=0u as=0p ps=0u
M5 pN2 f VCC VCC PMOS W=1.5u L=0.05u
+ ad=0p pd=0u as=0p ps=0u
M6 Y d pN4 VCC PMOS W=1.5u L=0.05u
+ ad=0p pd=0u as=0p ps=0u
M7 Y f pN4 VCC PMOS W=1.5u L=0.05u
+ ad=0p pd=0u as=0p ps=0u
M8 Y c pN1 VCC PMOS W=1u L=0.05u
+ ad=0p pd=0u as=0p ps=0u
M9 Y b pN4 VCC PMOS W=1.5u L=0.05u
+ ad=0p pd=0u as=0p ps=0u
M10 nN1 a GND GND NMOS W=0.75u L=0.05u
+ ad=0p pd=0u as=0p ps=0u
M11 Y a nN3 GND NMOS W=0.75u L=0.05u
+ ad=0p pd=0u as=0p ps=0u
M12 nN3 c GND GND NMOS W=1u L=0.05u
+ ad=0p pd=0u as=0p ps=0u
M13 nN3 d nN1 GND NMOS W=1u L=0.05u
+ ad=0p pd=0u as=0p ps=0u
M14 Y b nN2 GND NMOS W=1u L=0.05u
+ ad=0p pd=0u as=0p ps=0u
M15 nN2 f nN1 GND NMOS W=1u L=0.05u
+ ad=0p pd=0u as=0p ps=0u
M16 Y e nN3 GND NMOS W=0.75u L=0.05u
+ ad=0p pd=0u as=0p ps=0u
.end
